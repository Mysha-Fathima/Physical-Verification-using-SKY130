**.subckt INVERTER-1
**.ends
** flattened .save nodes
.end
